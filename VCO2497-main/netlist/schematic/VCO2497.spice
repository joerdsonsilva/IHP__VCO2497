** sch_path: /home/Joerdson/IHP-Open-PDK/ihp-sg13g2/libs.tech/xschem/cryovco.sch
.subckt VCO2497 VCC LOP GND VCTR ICC LON
L1 VCC LOP GND inductor w=3e-6 s=3e-6 d=80e-6 nr_r=3 m=1
R1 VCC LOP GND rppd w=9.34e-6 l=10.97e-6 m=1 b=0
C1 VCC LOP cap_cmim w=9.62e-6 l=12.54e-6 m=1
L2 VCC LON GND inductor w=3e-6 s=3e-6 d=80e-6 nr_r=3 m=1
R2 VCC LON GND rppd w=9.34e-6 l=10.97e-6 m=1 b=0
C2 VCC LON cap_cmim w=9.62e-6 l=12.54e-6 m=1
C3 LOP VCTR LON GND sg13_hv_svaricap w=9.74u l=0.8u Nx=3
M3 LOP LON net1 GND sg13_lv_nmos w=40u l=0.13u ng=5 m=1
M4 LON LOP net1 GND sg13_lv_nmos w=40u l=0.13u ng=5 m=1
M2 net1 ICC GND GND sg13_lv_nmos w=120u l=0.13u ng=15 m=1
M1 ICC ICC GND GND sg13_lv_nmos w=120u l=0.13u ng=15 m=1
.ends
.end
